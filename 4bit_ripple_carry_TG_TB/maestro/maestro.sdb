ADE simulation setup
Run mode: Single Run, Sweeps and Corners
Tests:
  vlsiProject_4bit_ripple_carry_TG_TB_1: vlsiProject/4bit_ripple_carry_TG_TB/schematic, simulator spectre
    Variables: WN = 80n; WP = 80n
