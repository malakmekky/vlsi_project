ADE simulation setup
Run mode: Single Run, Sweeps and Corners
Tests:
  vlsiProject_full_adder_buffer_TB_1: vlsiProject/full_adder_buffer_TB/schematic, simulator spectre
    Variables: wn = 80n; WN = 80n; WP = 80n; wp = 80n
