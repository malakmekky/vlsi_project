ADE simulation setup
Run mode: Single Run, Sweeps and Corners
Tests:
  vlsiProject_inverter_TB_1: vlsiProject/inverter_TB/schematic, simulator spectre
    Variables: wn = 80n; wp = 80n
