ADE simulation setup
Run mode: Single Run, Sweeps and Corners
Tests:
  vlsiProject_inverter_TB_1: vlsiProject/inverter_TB/schematic, simulator spectre
    Variables: WN = 65n*k; WP = 65n*k*2.5122; k = 1:12
    Outputs: delay(?wf1 VT("/net1") ?value1 0.4 ?edge1 "falling" ?nth1 1 ?td1 0.0 ?tol1 nil ?wf2 VT("/net2") ?value2 0.5 ?edge2 "rising" ?nth2 0 ?tol2 nil ?td2 nil ?stop nil ?multiple nil); delay(?wf1 VT("/net1") ?value1 0.5 ?edge1 "falling" ?nth1 1 ?td1 0.0 ?tol1 nil ?wf2 VT("/net2") ?value2 0.5 ?edge2 "rising" ?nth2 0 ?tol2 nil ?td2 nil ?stop nil ?multiple nil); delay(?wf1 VT("/net1") ?value1 0.5 ?edge1 "rising" ?nth1 1 ?td1 0.0 ?tol1 nil ?wf2 VT("/net2") ?value2 0.5 ?edge2 "falling" ?nth2 0 ?tol2 nil ?td2 nil ?stop nil ?multiple nil)
