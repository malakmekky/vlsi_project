ADE simulation setup
Run mode: Single Run, Sweeps and Corners
Tests:
  vlsiProject_full_adder_tb_1: vlsiProject/full_adder_tb/schematic, simulator spectre
    Variables: wn = 80n; WN = 80n; WP = 80n; wp = 80n
