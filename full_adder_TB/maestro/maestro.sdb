ADE simulation setup
Run mode: Single Run, Sweeps and Corners
Tests:
  vlsiProject_full_adder_TB_1: vlsiProject/full_adder_TB/schematic, simulator spectre
    Variables: WN = 80n; WP = 80n
