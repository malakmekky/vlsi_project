ADE simulation setup
Run mode: Single Run, Sweeps and Corners
Tests:
  vlsiProject_2_ip_OR_TB_1: vlsiProject/2_ip_OR_TB/schematic, simulator spectre
    Variables: wn = 80n; wp = 80n
    Outputs: Pavg
