ADE simulation setup
Run mode: Single Run, Sweeps and Corners
Tests:
  vlsiProject_4bit_ripple_carry_TG_sub_TB_1: vlsiProject/4bit_ripple_carry_TG_sub_TB/schematic, simulator spectre
    Variables: A0 = 1; A1 = 0; A2 = 0; A3 = 0; B0 = 0; B1 = 1; B2 = 0; B3 = 1; CIN = 1; CLK = 0; WN = 80n; WP = 80n
