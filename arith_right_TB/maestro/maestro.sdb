ADE simulation setup
Run mode: Single Run, Sweeps and Corners
Tests:
  malak_arith_right_TB_1: malak/arith_right_TB/schematic, simulator spectre
    Variables: A0 = 1; A1 = 0; A2 = 0; A3 = 1; S0 = 0; S1 = 0; S2 = 0; S3 = 1; WN = 80n
