ADE simulation setup
Run mode: Single Run, Sweeps and Corners
Tests:
  vlsiProject_buffer_TB_1: vlsiProject/buffer_TB/schematic, simulator spectre
    Variables: wn = 80n; wp = 80n
